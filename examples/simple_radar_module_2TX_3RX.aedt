# Ansys Electronics Desktop project, version 2022.2
materials:
  Rogers RT/duroid 5880 (tm): permittivity=2.2 dielectric_loss_tangent=0.0009
  UltradurÂ® B 4300 G6: permittivity=3.8 dielectric_loss_tangent=0.017
  copper: permeability=0.999991 conductivity=58000000
  vacuum: permittivity=1

design 0_radar_modul (HFSS, DrivenTerminal, model units mm)
options: Allow_Material_Override
variables:
  num_seg_wire = 6
  offs_FEBI = 0.5mm
geometry:
  coordinate_system RelativeCS18 = origin=(258.26mm, 70.5mm, 0mm) x=(1mm, 0mm, 0mm) y=(0mm, 1mm, 0mm)
  Substrate [Rogers RT/duroid 5880 (tm)] = imported_body() in RelativeCS18
  Substrate.move(0mm, -49.846422mm, 0mm) in RelativeCS18
  GND [copper] = imported_body() in RelativeCS18
  GND.move(0mm, -49.846422mm, 0mm) in RelativeCS18
  p1_Rx1 [copper] = imported_body() in RelativeCS18
  p1_Rx1.move(0mm, -49.846422mm, 0mm) in RelativeCS18
  p1_Tx1 [copper] = imported_body() in RelativeCS18
  p1_Tx1.move(0mm, -49.846422mm, 0mm) in RelativeCS18
  p1_Rx2 [copper] = imported_body() in RelativeCS18
  p1_Rx2.move(0mm, -49.846422mm, 0mm) in RelativeCS18
  p1_Rx3 [copper] = imported_body() in RelativeCS18
  p1_Rx3.move(0mm, -49.846422mm, 0mm) in RelativeCS18
  p1_Tx2 [copper] = imported_body() in RelativeCS18
  p1_Tx2.move(0mm, -49.846422mm, 0mm) in RelativeCS18
  coordinate_system RelativeCS19 = origin=(258.26mm, -70.5mm, 46.5mm) x=(1mm, 0mm, 0mm) y=(0mm, 1mm, 0mm)
  coordinate_system RelativeCS20 = origin=(2mm, 0mm, 0mm) x=(1mm, 0mm, 0mm) y=(0mm, 1mm, 0mm) in RelativeCS19
  [p1_Rx1, p1_Rx2, p1_Rx3].move(0mm, 3.8934085mm, 0mm)
  Substrate.move_faces(MoveAlongNormalFlag=false MoveVectorX=0mm MoveVectorY=5mm MoveVectorZ=0mm FacesToMove=?.face(#43295, #43297, #43298))
  GND.move_faces(MoveAlongNormalFlag=false MoveVectorX=0mm MoveVectorY=5mm MoveVectorZ=0mm FacesToMove=?.face(#43537, #43539, #43540))
  patches [copper] = imported_body()
  coordinate_system RelativeCS21 = origin=(255.405mm, 3mm, 0mm) x=(1mm, 0mm, 0mm) y=(0mm, 1mm, 0mm)
  coordinate_system RX1 = origin=(2.837mm, -11.212041mm, -1.464784mm) x=(1mm, 0mm, 0mm) y=(0mm, 1mm, 0mm) in RelativeCS21
  coordinate_system RelativeCS22 = origin=(-0.018mm, -78.712041mm, -1.464784mm) x=(1mm, 0mm, 0mm) y=(0mm, 1mm, 0mm) in RelativeCS18
  coordinate_system RX2 = origin=(0mm, 1.9467043mm, 0mm) x=(1mm, 0mm, 0mm) y=(0mm, 1mm, 0mm) in RX1
  coordinate_system RX3 = origin=(0mm, 1.9467043mm, 0mm) x=(1mm, 0mm, 0mm) y=(0mm, 1mm, 0mm) in RX2
  coordinate_system RX4 = origin=(0mm, 1.9467043mm, 0mm) x=(1mm, 0mm, 0mm) y=(0mm, 1mm, 0mm) in RX3
  coordinate_system TX1 = origin=(0mm, 7.6905597mm, 0mm) x=(1mm, 0mm, 0mm) y=(0mm, 1mm, 0mm) in RX4
  coordinate_system TX2 = origin=(0mm, 7.8830745mm, 0mm) x=(1mm, 0mm, 0mm) y=(0mm, 1mm, 0mm) in TX1
  patches_Separate1..patches_Separate4 [copper] = patches.separate_bodies()
  Region [vacuum] = region(absolute_offset=1mm on all sides) in TX2
boundaries and excitations:
  Rad1: Radiation Objects=Region
  patches_T1: Terminal port=1 Edges=?.edge(#43716) TerminalResistance=50ohm
  patches_T2: Terminal port=2 Edges=?.edge(#43805) TerminalResistance=50ohm
  patches_T3: Terminal port=3 Edges=?.edge(#43710) TerminalResistance=50ohm
  patches_T4: Terminal port=4 Edges=?.edge(#43686) TerminalResistance=50ohm
  patches_T5: Terminal port=5 Edges=?.edge(#43853) TerminalResistance=50ohm
  1: Lumped Port Faces=?.face(#43987) Impedance=50ohm
  2: Lumped Port Faces=?.face(#44011) Impedance=50ohm
  3: Lumped Port Faces=?.face(#44023) Impedance=50ohm
  4: Lumped Port Faces=?.face(#43999) Impedance=50ohm
  5: Lumped Port Faces=?.face(#44071) Impedance=50ohm
  reference conductors: GND
mesh:
  Length1: LengthBased Faces=?.face(#46637, #46517, #46618, #46401, #46602) MaxLength=0.08mm
  initial mesh: MeshMethod=AnsoftTAU
setups:
  Setup1: HfssDriven Frequency=77GHz MaxDeltaS=0.02 MaximumPasses=3 MinimumPasses=1 MinimumConvergedPasses=1 PercentRefinement=30 BasisOrder=-1 PortAccuracy=2 DrivenSolverType="Domain Decomposition" IterativeResidual=1e-06 DDMSolverResidual=0.0001
source amplitudes:
  1:1: 1V 0deg
  2:1, 3:1, 4:1, 5:1: 0V 0deg
optimetrics:
  ParametricSetup1: Parametric Sim._Setups=[Setup1]
    sweep offs_FEBI: LIN 0mm 0.5mm 0.05mm
radiation setups:
  Sphere_Custom: Infinite Sphere Theta=0deg..180deg step 2deg Phi=-180deg..180deg step 2deg
field plots:
  Mesh1: MeshPlots on Setup1 : LastAdaptive at Freq=77GHz Phase=0deg
  Mag_Jsurf1: Jsurf on Setup1 : LastAdaptive at Freq=77GHz Phase=0deg
